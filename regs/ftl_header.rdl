// The header of the SSD's flash translation layer on its NAND, in the
// reserve at the NAND's start: docs/models/ssd-firmware.md.
//
// A header is a file format and not a block's registers. It is still a
// list of named 32-bit words at offsets, read and written by the
// firmware's C and by Python, which is what this language and its
// generator are for.
//
// tools/regs.py writes the C header, the Python module and the table in
// that page from this file. `uv run python tools/lint.py --fix` runs it.

`include "properties.rdl"

// What says a header is one. The bytes are "SFTL", in the order a hex dump
// shows them.
enum ftl_header_magic_e {
    NUMBER = 0x4C544653 { desc = "The four bytes `SFTL`, which as a little-endian number is 0x4C544653."; };
};

enum ftl_header_version_e {
    FIRST = 1 { desc = "The header, then the table from the reserve's second page: for each page of the drive, the NAND page that holds it, a 32-bit word, all ones for none."; };
};

addrmap ftl_header {
    name = "FTL header";
    desc = "The first page of the reserve: whose table follows it, and where the next page the drive is written to goes.";
    block_size = 0x10;
    default regwidth = 32;

    reg {
        desc = "What says this is the FTL's header at all. A NAND never programmed reads all ones here, and holds a drive of zeros.";
        field { sw = r; encode = ftl_header_magic_e; } VALUE[31:0] = 0;
    } MAGIC @ 0x00;

    reg {
        desc = "Which layout the table that follows is in.";
        field { sw = r; encode = ftl_header_version_e; } VALUE[31:0] = 0;
    } VERSION @ 0x04;

    reg {
        desc = "How many pages the drive has, and so how many entries the table: a table for a drive of another size is not this one's.";
        field { sw = r; } VALUE[31:0] = 0;
    } PAGES @ 0x08;

    reg {
        desc = "The next NAND page nobody has: where the next page of the drive that no NAND page holds yet is written.";
        field { sw = r; } VALUE[31:0] = 0;
    } NEXT_FREE @ 0x0C;
};
