// The two registers that every device given one command at a time has
// beside its command register: how the last command went, and which of
// that interrupts. The DMA engine and the flash controller both have
// them, at the same offsets, so that a driver for one is most of a driver
// for the other.
//
// Nothing is generated from this file. A block's map includes it and has
// the registers by their types.

reg command_status_r {
    desc = "How the last command went. Giving the next command forgets it.";
    field {
        sw = rw; onwrite = woclr;
        desc = "The command was carried out.";
    } DONE[0:0] = 0;
    field {
        sw = rw; onwrite = woclr;
        desc = "The command was not carried out, or not all of it.";
    } ERROR[1:1] = 0;
    field {
        sw = r;
        desc = "A command has been given and is not yet carried out. No other is taken meanwhile.";
    } BUSY[2:2] = 0;
};

reg command_interrupt_enable_r {
    desc = "Which bits of `STATUS` raise the interrupt line while they are set.";
    field { sw = rw; } DONE[0:0] = 0;
    field { sw = rw; } ERROR[1:1] = 0;
};
