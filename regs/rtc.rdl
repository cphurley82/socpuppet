// The real-time clock: docs/models/rtc.md.
//
// The register map of the Goldfish real-time clock, the one QEMU's `virt`
// machine and Android's emulator have, which Linux's `rtc-goldfish` drives.
// Time is in nanoseconds since 1970, a 64-bit count read and written as two
// 32-bit halves.
//
// tools/regs.py writes the C header, the Python module and the table in
// that page from this file. `uv run python tools/lint.py --fix` runs it.

`include "properties.rdl"

addrmap rtc {
    name = "Real-time clock";
    desc = "The time of day, in nanoseconds since 1970, and an alarm at a time to come.";
    block_size = 0x1000;
    default regwidth = 32;

    reg {
        desc = "The low half of the time. Reading it keeps the high half as it was then, for `TIME_HIGH`; writing it sets the time, with the high half written to `TIME_HIGH` before.";
        field { sw = rw; } VALUE[31:0] = 0;
    } TIME_LOW @ 0x00;

    reg {
        desc = "The high half of the time: as it was when `TIME_LOW` was last read, or as last written, for a write of `TIME_LOW` to set.";
        field { sw = rw; } VALUE[31:0] = 0;
    } TIME_HIGH @ 0x04;

    reg {
        desc = "The low half of the alarm's time. Writing it sets the alarm, with the high half written to `ALARM_HIGH` before.";
        field { sw = rw; } VALUE[31:0] = 0;
    } ALARM_LOW @ 0x08;

    reg {
        desc = "The high half of the alarm's time.";
        field { sw = rw; } VALUE[31:0] = 0;
    } ALARM_HIGH @ 0x0C;

    reg {
        desc = "Whether the alarm, when it goes off, raises the interrupt.";
        field { sw = rw; } ENABLED[0:0] = 0;
    } IRQ_ENABLED @ 0x10;

    reg {
        desc = "Writing anything takes the alarm off.";
        field { sw = w; } VALUE[31:0] = 0;
    } CLEAR_ALARM @ 0x14;

    reg {
        desc = "Whether the alarm is set and has not gone off.";
        field { sw = r; } SET[0:0] = 0;
    } ALARM_STATUS @ 0x18;

    reg {
        desc = "Writing anything clears the interrupt the alarm raised.";
        field { sw = w; } VALUE[31:0] = 0;
    } CLEAR_INTERRUPT @ 0x1C;
};
