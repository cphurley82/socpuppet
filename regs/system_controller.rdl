// The system controller of a socpuppet CPU: docs/models/system-controller.md.
//
// tools/regs.py writes the C header, the Python module and the table in
// that page from this file. `uv run python tools/lint.py --fix` runs it.

`include "properties.rdl"

// Why a CPU was last reset.
enum system_controller_reset_cause_e {
    POWER_ON = 0 { desc = "The power came on, and nothing has reset the CPU since."; };
    WATCHDOG = 1 { desc = "The watchdog bit: firmware stopped feeding it."; };
    SOFTWARE = 2 { desc = "Firmware asked, by writing to `RESET_REQUEST`."; };
};

addrmap system_controller {
    name = "System controller";
    desc = "What a CPU asks about itself and its last reset, and the register that asks for one.";
    // Four registers, and room for four more.
    block_size = 0x20;
    default regwidth = 32;

    reg {
        desc = "Which die the CPU is on, as the number the board gave it.";
        field { sw = r; } VALUE[31:0] = 0;
    } DIE @ 0x00;

    reg {
        desc = "Where the CPU's boot ROM finds the image to start: the address of the image's header.";
        field { sw = r; } VALUE[31:0] = 0;
    } BOOT_ADDRESS @ 0x04;

    reg {
        desc = "Why the CPU was last reset.";
        field { sw = r; encode = system_controller_reset_cause_e; } VALUE[31:0] = 0;
    } RESET_CAUSE @ 0x08;

    reg {
        desc = "Asks for a reset of the CPU. Reads as zero.";
        field { sw = w; desc = "Write a one to reset the CPU."; } RESET[0:0] = 0;
    } RESET_REQUEST @ 0x0C;
};
